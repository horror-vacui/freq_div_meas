// ------------------------------------------------------------------------------------------
// Testbench helper for frequency dividers
//		It generates and sweeps the input signal in power and frequency for the divider and checks the divided signal.
//		The output is written into the spectre.log and into a csv file (defined by CDF parameters).
//
//	Set the simulation time long enough, the module will automatically end the simulation when it has finished.
// ------------------------------------------------------------------------------------------

`include "constants.vams"
`include "disciplines.vams"

module meas_freq_div(Out,InDiv,vss,vdc0,vdc1,vdc2,vdc3);
inout vss,InDiv;
output Out,vdc0,vdc1,vdc2,vdc3;
electrical Out,InDiv,vss,vdc0,vdc1,vdc2,vdc3;

parameter integer freq_ratio 	  = 4;     // division ratio
parameter real    tolerance 		= 1e-2;  // relative tolerance of the freq criteriato
parameter integer oversample		= 8;     // oversampling factor for the verilogA module
parameter integer checkmatches 	= 3; 		// consecutive checks wether calcratio matches freq_ratio or not
parameter real 	  fmin 		 	    = 0.5e9;
parameter real 	  fstep 	 		  = 0.5e9;	// freq sweep srtup
parameter real 	  fmax  			  = 13e9;
parameter real 	  out_DC 			  = 0; 		// DC voltage
parameter real 	  voutstep 		  = 0.75;     // voltage step; new voltage=ol_voltage*voutstep
parameter real 	  vmin   			  = 10m;
parameter real 	  vmax   			  = 1;
parameter real    vdd           = 0.8;
parameter real    InDiv_th			= 0.0;
parameter real 	  rout   			  = 50; 	// Reference resistance for power to voltage conversion
parameter real  	out_delay 		= 1n; 	// delay for settling the transient operation point
parameter string sensitivity_file	= "./divider_sensitivity.csv";
parameter string detailed_file		= "./divider.csv";
parameter string out_file_comment	= "Used for my_simulation testbench";
parameter string vdc0_name	= "core";
parameter string vdc1_name	= "buf";
parameter string vdc2_name	= "bias";
parameter string vdc3_name	= "backgate";
parameter integer debug=1;

real fc,phase; 	// input frequency and phase
real A;			    // output power
real Afmin=100;
real T,tlast,f_error;
real last_pout_integ, pout_integ, last_pout;
real last_pin_integ, pin_integ, last_pin;
real pvdd_core_integ,pvdd_buf_integ;
real last_pvdd_core_integ,last_pvdd_buf_integ;
real last_pvdd_core,last_pvdd_buf;
real next_wd_event = 10n;

string tmp       = "";

integer m;	// counter for consecutive good division periods
integer nm; // counter for consecutive failed division periods
integer nfv = 0; //4*checkmatches - same freq and voltage --> to avoid infinite loop if pass and fail periods are coming after each other
integer fp,fs;			// file pointers
integer Ff=0;		// divider operated in this freq.
integer Fop=0;
integer Fup=0;

// ------------------------------------------------------------------------------------------
`define counter_reset	m = 0; nm = 0; Ff=0;
`define calc_wd_time    $abstime + 10*checkmatches/fc;
`define disp_fA $display("Vin=%g, f=%g",A,fc);
`define new_fc \
	if (Afmin<100) begin \
		$fwrite(fs,"%e,%e\n",fc/1e9,Afmin); \
		A = Afmin; \
	end \
	else A = vmax; \
	fc = fc - fstep;  \
	if (fc<fmin || fc>fmax) $finish_current_analysis; \
	$display("Changing the frequency to %rHz", fc); 	 \
	m = 0; nm = 0; Ff = 0; Fup=0; nfv = 0; Afmin=100; \
	`disp_fA

// ------------------------------------------------------------------------------------------
analog begin
	@(initial_step) begin
		fc 		 = fmax;
		A 		 = vmax;
		`counter_reset
		last_pout_integ= 0;
		pout_integ	 = 0;
   	  	pin_integ	 = 0;
      	pvdd_core_integ = 0;
      	pvdd_buf_integ = 0;
      	last_pvdd_core_integ = 0;
      	last_pvdd_buf_integ = 0;

		fp=$fopen(detailed_file,"w");
		$fwrite(fp,";##################################################################\n");
		$fwrite(fp,";Generated by Spectre from Module %M\n");
		$fwrite(fp,";Comment: %s\n\n", out_file_comment);
		$fwrite(fp,";Settings:\n");
		$fwrite(fp,";Ratio= %d \n",freq_ratio);
		$fwrite(fp,";Ratiochecks= %d \n",checkmatches);
		$fwrite(fp,";Voltage step ratio= %e \n",voutstep);
		$fwrite(fp,";Fmin - Fmax = %r GHz ... %r GHz \n",fmin/1e9,fmax/1e9);
		$fwrite(fp,";Frequencysteps= %r GHz \n",fstep/1e9);
		$fwrite(fp,";Frequency [GHz],min Vin,Pclk,Pload,%s,%s\n",vdc0_name,vdc1_name);

		fs=$fopen(sensitivity_file,"w");
		$fwrite(fs,";Frequency [GHz],min Vin\n");

		$strobe("Next watchdog item: %r",next_wd_event);
	end // initial step

  $bound_step(1/(fc*oversample));

  phase = `M_TWO_PI*idtmod(fc,0,1,0);
  pout_integ     = idt(V(Out,vss)*I(Out,vss),0);	// integrated power of Out (=clk input terminal of the divider)
  pin_integ   = idt(V(InDiv,vss)*I(InDiv,vss),0);	// integrated power of  InDiv, i.e. output power of the divider.
  pvdd_core_integ = idt(V(vdc0,vss)*I(vdc0,vss),0);	// integrated power of vdd0
  pvdd_buf_integ = idt(V(vdc1,vss)*I(vdc1,vss),0);		// integrated power of vdd1

// ------------------------------------------------------------------------------------------
// watchdog: too high or too low frequency will not initiate any signal crossing at the input
  @(timer(next_wd_event)) begin
		$strobe("No transitions has been detcted at the module input. Stepping Frequency. @%r",$abstime);
		next_wd_event = `calc_wd_time
		`new_fc
	end

// ------------------------------------------------------------------------------------------
// Main loop
  @(cross(V(InDiv,vss)-InDiv_th,1)) begin  // rising edges of the zero crossings of InDiv
	if( $abstime > out_delay ) begin
		nfv = nfv + 1;
		next_wd_event = `calc_wd_time	// set watchdog
		T     = $abstime - tlast;		// measured period of the divider output
		tlast = $abstime;

		// average power in the last output cycle:
		last_pout      	= -(pout_integ     	- last_pout_integ ) 		  / T; // =clk input terminal of the divider
		last_pin      	= -(pin_integ   		- last_pin_integ  ) 		  / T; // output of the divider
		last_pvdd_core  = -(pvdd_core_integ 	- last_pvdd_core_integ) / T; // core vdd
		last_pvdd_buf   = -(pvdd_buf_integ 	- last_pvdd_buf_integ)    / T;  // buf vdd

		// saving the actual integrated power for the next cycle for the calculation above
		last_pout_integ       = pout_integ;
		last_pin_integ        = pin_integ;
		last_pvdd_core_integ  = pvdd_core_integ;
		last_pvdd_buf_integ   = pvdd_buf_integ;

		f_error = abs(T*fc/freq_ratio -1); // relative frequency error
		if (f_error <= tolerance) begin // PASS condition
			 tmp = "PASS"; m = m+1; nm = 0;
		end
		else begin	// FAIL condition
			 $display("Tolerance was not met: %r > %r ",f_error,tolerance);
			 tmp = "FAIL"; nm = nm+1; m = 0;
		end
		$display("F= %r GHz: Vamp= %r V; Pout= %r dBm; Fout= %r GHz... %s",fc/1e9,A,10*log(last_pout)+30,1/T/1e9,tmp);

    // ------------------------------------------------------------
		if (m == checkmatches) begin // correct divider operation; checkmatches --> consecutive good periods
			`counter_reset
			Fop = 1;	 Ff=1;
			if (A<Afmin) Afmin=A;
			$fclose(fp); // otherwise only the first 8192 characters will be displayed.
			fp=$fopen(detailed_file,"a");
			$fwrite(fp,"%e,%e,%e,%e,%e,%e\n",fc/1e9,A,last_pout,last_pin,last_pvdd_core,last_pvdd_buf);
			if (Fup == 1) begin	// fist operating condition since we are increasing the input amplitude
					$display("F= %r GHz: Vmin= %r V; Pout= %r dBm; PDC= %r",fc/1e9,A,10*log(-last_pout)+30,last_pvdd_core*1e3);
					`new_fc
			end
			else begin
				if (A * voutstep <= vmin) begin // avoid infinite loop due to the the self resonance of the divider
					$display("Input power reached the minimum threshold; moving to next frequency");
					`new_fc
				end
				else begin
					 A = A * voutstep; // decrease output power
					 $display("FD operating... decrease power");
					 `disp_fA
					 nfv = 0;
				end
			end
		end // if(matches == checkmatches)

    // ------------------------------------------------------------
		if (nm >= checkmatches || nfv >= 4*checkmatches) begin  // incorrect divider operation; "checkmatches" consecutive failed period
			if (debug != 0) $display("FD not operating... nm: %d; nfv: %d; Fop: %d; Ff %d; A/S: %e, %e, %g, %g", nm, nfv, Fop, Ff, A/voutstep, vmax, A/voutstep<=vmax, 0.4 <= 0.4);
			if (Ff == 0) begin // was there operation at this frequency?
				if (A / voutstep <= vmax*1.001) begin
					$display("No reliable operation with the current settings. Increasing input power.");
					Fup = 1;
					A = A / voutstep;
					`disp_fA
					nfv = 0; nm=01; m=0;
				end // if (A / voutstep <= vmax)
				else begin
					$display("The maximum input power has been reached");
					if (Fop == 1) $finish_current_analysis;
					else begin
						$display("The reliable operating frequence range of the FD has not been reached yet.");
						`new_fc
					end // if Fop==1
				end // else A/voutstep
			end // if Ff==0
			else begin // there was oepration at this frequency.
				`new_fc
			end
		end  // if(nm==check...)
	end // if($abstime...
  end // cross

  // ------------------------------------------------------------
  V(Out,vss)   <+ out_DC + transition(A,0,10p)*cos(phase);
  V(vdc0,vss)  <+ vdd;
  V(vdc1,vss)  <+ vdd;
  I(InDiv,vss) <+ V(InDiv,vss)/rout;

  // ------------------------------------------------------------
  @(final_step) begin  // close the file
		$fclose(fp);
		$fclose(fs);
  end
end // analog
endmodule
